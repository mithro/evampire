* 10 diode-connected nfet_05v0 in series, variant A_shared_substrate
.include /foss/pdks/gf180mcuD/libs.tech/ngspice/design.ngspice
.lib /foss/pdks/gf180mcuD/libs.tech/ngspice/sm141064.ngspice typical
.lib /foss/pdks/gf180mcuD/libs.tech/ngspice/sm141064.ngspice diode_typical

VIN n0 0 0
VBOT n10 0 0
VSUB sub 0 0

XM1 n0 n0 n1 b1 nfet_05v0 w=1e-05 l=6e-07 ad=1.8e-12 as=1.8e-12 pd=2.036e-05 ps=2.036e-05
VB1 b1 sub 0
DJD1 sub n0 diode_nd2ps_06v0 area=1.8e-12 pj=2.036e-05
DJS1 sub n1 diode_nd2ps_06v0 area=1.8e-12 pj=2.036e-05
XM2 n1 n1 n2 b2 nfet_05v0 w=1e-05 l=6e-07 ad=1.8e-12 as=1.8e-12 pd=2.036e-05 ps=2.036e-05
VB2 b2 sub 0
DJD2 sub n1 diode_nd2ps_06v0 area=1.8e-12 pj=2.036e-05
DJS2 sub n2 diode_nd2ps_06v0 area=1.8e-12 pj=2.036e-05
XM3 n2 n2 n3 b3 nfet_05v0 w=1e-05 l=6e-07 ad=1.8e-12 as=1.8e-12 pd=2.036e-05 ps=2.036e-05
VB3 b3 sub 0
DJD3 sub n2 diode_nd2ps_06v0 area=1.8e-12 pj=2.036e-05
DJS3 sub n3 diode_nd2ps_06v0 area=1.8e-12 pj=2.036e-05
XM4 n3 n3 n4 b4 nfet_05v0 w=1e-05 l=6e-07 ad=1.8e-12 as=1.8e-12 pd=2.036e-05 ps=2.036e-05
VB4 b4 sub 0
DJD4 sub n3 diode_nd2ps_06v0 area=1.8e-12 pj=2.036e-05
DJS4 sub n4 diode_nd2ps_06v0 area=1.8e-12 pj=2.036e-05
XM5 n4 n4 n5 b5 nfet_05v0 w=1e-05 l=6e-07 ad=1.8e-12 as=1.8e-12 pd=2.036e-05 ps=2.036e-05
VB5 b5 sub 0
DJD5 sub n4 diode_nd2ps_06v0 area=1.8e-12 pj=2.036e-05
DJS5 sub n5 diode_nd2ps_06v0 area=1.8e-12 pj=2.036e-05
XM6 n5 n5 n6 b6 nfet_05v0 w=1e-05 l=6e-07 ad=1.8e-12 as=1.8e-12 pd=2.036e-05 ps=2.036e-05
VB6 b6 sub 0
DJD6 sub n5 diode_nd2ps_06v0 area=1.8e-12 pj=2.036e-05
DJS6 sub n6 diode_nd2ps_06v0 area=1.8e-12 pj=2.036e-05
XM7 n6 n6 n7 b7 nfet_05v0 w=1e-05 l=6e-07 ad=1.8e-12 as=1.8e-12 pd=2.036e-05 ps=2.036e-05
VB7 b7 sub 0
DJD7 sub n6 diode_nd2ps_06v0 area=1.8e-12 pj=2.036e-05
DJS7 sub n7 diode_nd2ps_06v0 area=1.8e-12 pj=2.036e-05
XM8 n7 n7 n8 b8 nfet_05v0 w=1e-05 l=6e-07 ad=1.8e-12 as=1.8e-12 pd=2.036e-05 ps=2.036e-05
VB8 b8 sub 0
DJD8 sub n7 diode_nd2ps_06v0 area=1.8e-12 pj=2.036e-05
DJS8 sub n8 diode_nd2ps_06v0 area=1.8e-12 pj=2.036e-05
XM9 n8 n8 n9 b9 nfet_05v0 w=1e-05 l=6e-07 ad=1.8e-12 as=1.8e-12 pd=2.036e-05 ps=2.036e-05
VB9 b9 sub 0
DJD9 sub n8 diode_nd2ps_06v0 area=1.8e-12 pj=2.036e-05
DJS9 sub n9 diode_nd2ps_06v0 area=1.8e-12 pj=2.036e-05
XM10 n9 n9 n10 b10 nfet_05v0 w=1e-05 l=6e-07 ad=1.8e-12 as=1.8e-12 pd=2.036e-05 ps=2.036e-05
VB10 b10 sub 0
DJD10 sub n9 diode_nd2ps_06v0 area=1.8e-12 pj=2.036e-05
DJS10 sub n10 diode_nd2ps_06v0 area=1.8e-12 pj=2.036e-05

.option gmin=1e-15 reltol=1e-4
.dc VIN 0 100.0 0.05
.control
set wr_singlescale
set wr_vecnames
run
wrdata A_shared_substrate.dat v(n1) v(n2) v(n3) v(n4) v(n5) v(n6) v(n7) v(n8) v(n9) i(VB1) i(VB2) i(VB3) i(VB4) i(VB5) i(VB6) i(VB7) i(VB8) i(VB9) i(VB10) i(VIN) i(VBOT) i(VSUB)
quit
.endc
.end
