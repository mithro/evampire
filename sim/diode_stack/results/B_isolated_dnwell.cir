* 10 diode-connected nfet_05v0 in series, variant B_isolated_dnwell
.include /foss/pdks/gf180mcuD/libs.tech/ngspice/design.ngspice
.lib /foss/pdks/gf180mcuD/libs.tech/ngspice/sm141064.ngspice typical
.lib /foss/pdks/gf180mcuD/libs.tech/ngspice/sm141064.ngspice diode_typical

VIN n0 0 0
VBOT n10 0 0
VSUB sub 0 0

XM1 n0 n0 n1 n1 nfet_05v0 w=1e-05 l=6e-07 ad=1.8e-12 as=1.8e-12 pd=2.036e-05 ps=2.036e-05
DND1 n1 n0 diode_nd2ps_06v0 area=1.8e-12 pj=2.036e-05
DPW1 n1 n0 diode_pw2dw area=2.56e-10 pj=6.4e-05
DDW1 sub n0 diode_dw2ps area=4e-10 pj=8e-05
XM2 n1 n1 n2 n2 nfet_05v0 w=1e-05 l=6e-07 ad=1.8e-12 as=1.8e-12 pd=2.036e-05 ps=2.036e-05
DND2 n2 n1 diode_nd2ps_06v0 area=1.8e-12 pj=2.036e-05
DPW2 n2 n1 diode_pw2dw area=2.56e-10 pj=6.4e-05
DDW2 sub n1 diode_dw2ps area=4e-10 pj=8e-05
XM3 n2 n2 n3 n3 nfet_05v0 w=1e-05 l=6e-07 ad=1.8e-12 as=1.8e-12 pd=2.036e-05 ps=2.036e-05
DND3 n3 n2 diode_nd2ps_06v0 area=1.8e-12 pj=2.036e-05
DPW3 n3 n2 diode_pw2dw area=2.56e-10 pj=6.4e-05
DDW3 sub n2 diode_dw2ps area=4e-10 pj=8e-05
XM4 n3 n3 n4 n4 nfet_05v0 w=1e-05 l=6e-07 ad=1.8e-12 as=1.8e-12 pd=2.036e-05 ps=2.036e-05
DND4 n4 n3 diode_nd2ps_06v0 area=1.8e-12 pj=2.036e-05
DPW4 n4 n3 diode_pw2dw area=2.56e-10 pj=6.4e-05
DDW4 sub n3 diode_dw2ps area=4e-10 pj=8e-05
XM5 n4 n4 n5 n5 nfet_05v0 w=1e-05 l=6e-07 ad=1.8e-12 as=1.8e-12 pd=2.036e-05 ps=2.036e-05
DND5 n5 n4 diode_nd2ps_06v0 area=1.8e-12 pj=2.036e-05
DPW5 n5 n4 diode_pw2dw area=2.56e-10 pj=6.4e-05
DDW5 sub n4 diode_dw2ps area=4e-10 pj=8e-05
XM6 n5 n5 n6 n6 nfet_05v0 w=1e-05 l=6e-07 ad=1.8e-12 as=1.8e-12 pd=2.036e-05 ps=2.036e-05
DND6 n6 n5 diode_nd2ps_06v0 area=1.8e-12 pj=2.036e-05
DPW6 n6 n5 diode_pw2dw area=2.56e-10 pj=6.4e-05
DDW6 sub n5 diode_dw2ps area=4e-10 pj=8e-05
XM7 n6 n6 n7 n7 nfet_05v0 w=1e-05 l=6e-07 ad=1.8e-12 as=1.8e-12 pd=2.036e-05 ps=2.036e-05
DND7 n7 n6 diode_nd2ps_06v0 area=1.8e-12 pj=2.036e-05
DPW7 n7 n6 diode_pw2dw area=2.56e-10 pj=6.4e-05
DDW7 sub n6 diode_dw2ps area=4e-10 pj=8e-05
XM8 n7 n7 n8 n8 nfet_05v0 w=1e-05 l=6e-07 ad=1.8e-12 as=1.8e-12 pd=2.036e-05 ps=2.036e-05
DND8 n8 n7 diode_nd2ps_06v0 area=1.8e-12 pj=2.036e-05
DPW8 n8 n7 diode_pw2dw area=2.56e-10 pj=6.4e-05
DDW8 sub n7 diode_dw2ps area=4e-10 pj=8e-05
XM9 n8 n8 n9 n9 nfet_05v0 w=1e-05 l=6e-07 ad=1.8e-12 as=1.8e-12 pd=2.036e-05 ps=2.036e-05
DND9 n9 n8 diode_nd2ps_06v0 area=1.8e-12 pj=2.036e-05
DPW9 n9 n8 diode_pw2dw area=2.56e-10 pj=6.4e-05
DDW9 sub n8 diode_dw2ps area=4e-10 pj=8e-05
XM10 n9 n9 n10 n10 nfet_05v0 w=1e-05 l=6e-07 ad=1.8e-12 as=1.8e-12 pd=2.036e-05 ps=2.036e-05
DND10 n10 n9 diode_nd2ps_06v0 area=1.8e-12 pj=2.036e-05
DPW10 n10 n9 diode_pw2dw area=2.56e-10 pj=6.4e-05
DDW10 sub n9 diode_dw2ps area=4e-10 pj=8e-05

.option gmin=1e-15 reltol=1e-4
.dc VIN 0 100.0 0.05
.control
set wr_singlescale
set wr_vecnames
run
wrdata B_isolated_dnwell.dat v(n1) v(n2) v(n3) v(n4) v(n5) v(n6) v(n7) v(n8) v(n9) i(VIN) i(VBOT) i(VSUB)
quit
.endc
.end
